simulator lang=spectre insensitive=yes
* EE5507 library
* modified for use with LTSpice; DM 8/19/2008
*
* 0.18u CMOS process
*
* NMOS transistor model name: NM
* PMOS transistor model name: PM

*as=(1.1u*W) ps=(2.2u+W) ad=(1.1u*W) pd=(2.2u+W)
*-----------------------------------------------------------------------
inline subckt NM (d g s b)
parameters w=1e-7 l=1e-6
+as=(1.1u*W) ps=(2.2u+W) ad=(1.1u*W) pd=(2.2u+W)
* ----------------------------------------------------------------------
* NMOS transistor model
* ----------------------------------------------------------------------
model NMOS bsim3v3
+type=n
* ----------------------------------------------------------------------
************************* SIMULATION PARAMETERS ************************
* ----------------------------------------------------------------------
* format    : LTspice
* model     : MOS BSIM3v3
* ----------------------------------------------------------------------
*                        TYPICAL MEAN CONDITION
* ----------------------------------------------------------------------
+version = 3.1
+tnom    = 27
+tox     = 4.1E-9
+xj      = 1E-7
+nch     = 2.3549E17
+vth0    = 0.354505
+k1      = 0.5733393
+k2      = 3.177172E-3
+k3      = 27.3563303
+k3b     = -10
+w0      = 2.341477E-5
+nlx     = 1.906617E-7
+dvt0w   = 0
+dvt1w   = 0
+dvt2w   = 0
+dvt0    = 1.6751718
+dvt1    = 0.4282625
+dvt2    = 0.036004
+u0      = 327.3736992
+ua      = -4.52726E-11
+ub      = 4.46532E-19
+uc      = -4.74051E-11
+vsat    = 8.785346E4
+a0      = 1.6897405
+ags     = 0.2908676
+b0      = -8.224961E-9
+b1      = -1E-7
+keta    = 0.021238
+a1      = 8.00349E-4
+a2      = 1
+rdsw    = 105
+prwg    = 0.5
+prwb    = -0.2
+wr      = 1
+wint    = 5e-9
+lint    = 2.351737E-8
+dwg     = 1.610448E-9
+dwb     = -5.108595E-9
+voff    = -0.0652968
+nfactor = 2.4901845
+cit     = 0
+cdsc    = 2.4E-4
+cdscd   = 0
+cdscb   = 0
+eta0    = 0.0231564
+etab    = -0.058499
+dsub    = 0.9467118
+pclm    = 0.8512348
+pdiblc1 = 0.0929526
+pdiblc2 = 0.01
+pdiblcb = -0.1
+drout   = 0.5224026
+pscbe1  = 7.979323E10
+pscbe2  = 1.522921E-9
+pvag    = 0.01
+delta   = 0.01
+rsh     = 6.8
+mobmod  = 1
+prt     = 0
+ute     = -1.5
+kt1     = -0.11
+kt1l    = 0
+kt2     = 0.022
+ua1     = 4.31E-9
+ub1     = -7.61E-18
+uc1     = -5.6E-11
+at      = 3.3E4
+wl      = 0
+wln     = 1
+ww      = 0
+wwn     = 1
+wwl     = 0
+ll      = 0
+lln     = 1
+lw      = 0
+lwn     = 1
+lwl     = 0
+capmod  = 2
+xpart   = 0.5
+cgdo    = 7.7E-10
+cgso    = 7.7E-10
+cgbo    = 1E-12
+cj      = 1.010083E-3
+pb      = 0.7344298
+mj      = 0.3565066
+cjsw    = 2.441707E-10
+pbsw    = 0.8005503
+mjsw    = 0.1327842
+cjswg   = 3.3E-10
+pbswg   = 0.8005503
+mjswg   = 0.1327842
+cf      = 0
+pvth0   = 1.307195E-3
+prdsw   = -5
+pk2     = -1.022757E-3
+wketa   = -4.466285E-4
+lketa   = -9.715157E-3
+pu0     = 12.2704847
+pua     = 4.421816E-11
+pub     = 0
+pvsat   = 1.707461E3
+peta0   = 1E-4
+pketa   = 2.348777E-3
NM (d g s b) NMOS
ends
