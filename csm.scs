********************************************
* File: sm079001-s11.mdl
*************************************************************************
* CSM BSIM3v3 Model for 0.25um 2.5V STI Salicide Process(3L215-A0B-50R)
* Doc # : YI-079-SM001
* Revision 1C
* LotName = 3XVT46050
* Wafer tested : #22
* Engineer : He Can Zhong
* Last Modification Date : Feb. 10, 1999
* Model parameters file for Spectre 4.4.1
*************************************************************************

model NMOS bsim3v3 type=n
+tnom=25.0
+version =3.1
+hdif= 0.305e-6
+tox= 5.10000E-09
+xj= 1.0000000E-07
+nch= 3.9150000E+17
+lln= 1.0000000
+lwn= 1.0000000
+wln= 1.0000000
+wwn= 1.0000000
+lint= 1.0000000E-08
+ll= 3.2000000E-15
+lw= 0.00
+lwl= 0.00
+wint= 5.5000000E-08
+wl= 0.00
+ww= -3.5000000E-15
+wwl= -1.7999999E-21
+mobmod=  1
+binunit= 2
+xl=  0
+xw=  0
+dwg= -1.0000000E-09
+dwb= 0.00
+vth0= 0.5145000 wvth0= -1.0000000E-08
+k1= 0.5497611
+k2= -8.6600000E-03
+k3= 40.5989400
+dvt0= 7.2000000
+dvt1= 0.5664879
+dvt2= -5.0000000E-03
+dvt0w= 1.4933270
+dvt1w= 2.6500000E+06
+dvt2w= 0.00
+nlx= 2.4593481E-07
+w0= 3.7500000E-06
+k3b= 5.8640200
+ngate= 1E30
+vsat= 1.0000000E+05 lvsat= -4.0000000E-03 wvsat= 6.0000000E-04 pvsat= -2.0000000E-10
+ua= 8.0000000E-11
+ub= 1.2000000E-18
+uc= 4.4899300E-11
+rdsw= 2.7275000E+02 lrdsw= -9.4000000E-06 wrdsw= -2.9999999E-05
+prwb= 0.00
+prwg= 5.0000000E-02
+wr= 1.0000000
+u0= 3.7000000E-02
+a0= 1.8099999
+keta= -1.0000000E-02
+a1= 0.00
+a2= 1.0000000
+ags= 0.3900000 pags= 6.0000000E-14
+b0= 4.0000000E-08
+b1= 0.00
+voff= -0.1187180
+nfactor= 0.8478104
+cit= 4.0000000E-04
+cdsc= 1.0000000E-03
+cdscb= 0.00
+cdscd= 1.0000000E-04
+eta0= 5.0000000E-02
+etab= -2.0000000E-02
+dsub= 0.3900000
+pclm= 2.0835919
+pdiblc1= 0.3717368
+pdiblc2= 3.6588570E-03
+pdiblcb= -1.0000000E-03
+drout= 0.8193588 pdrout= -7.0000000E-15
+pscbe1= 4.7700000E+08
+pscbe2= 3.4272980E-06
+pvag= 0.1802212
+delta= 1.0000000E-02
+alpha0= 0.00
+beta0= 30.0000000
+kt1= -0.2409119
+kt2= 0.00
+at= 1.0000000E+04 pat= 5.0000000E-10
+ute= -1.5500000
+ua1= 4.0700000E-10 wua1= -5.0000000E-17
+ub1= 1.0000000E-20 wub1= -1.4200000E-25
+uc1= -1.0000000E-13
+kt1l= 3.8349930E-09
+prt= -50.0000000
+cj= 1.241307E-03
+mj= 0.4960536
+pb= 0.9462224
+cjsw= 1.406401E-10
+mjsw= 0.3383889
+pbsw= 0.6743118
+cjswg= 4.895007E-10
+mjswg= 0.2253193
+pbswg= 0.8156778
+cta= 9.579374E-04
+ctp= 7.915575E-04
+pta= 1.577178E-03
+ptp= 2.535031E-03
+js=1E-14
+jsw=0
+n=1.0
+xti=3.0
+cgdo=3.73E-10
+cgso=3.73E-10
+cgbo=1.0E-13
+capmod= 2
+nqsmod= 0
+elm= 5
+xpart= 0
+cgsl= 1.25E-10
+cgdl= 1.25E-10
+ckappa= 0.05
+cf= 0
+clc= 1E-08
+cle= 2
+dlc= 3.4E-08
+dwc= 5.5E-08
+vfbcv= -1

model PMOS bsim3v3 type=p
+version =3.1
+hdif= 0.305e-6
+tox= 5.10000E-09
+xj= 1.0000000E-07
+nch= 5.4700000E+17
+lln= 1.0000000
+lwn= 1.0000000
+wln= 1.0000000
+wwn= 1.0000000
+lint= 3.1900000E-08
+ll= 0.00
+lw= 0.00
+lwl= 0.00
+wint= 2.7500000E-08
+wl= 0.00
+ww= 0.00
+wwl= 8.5000000E-22
+mobmod=  1
+binunit= 2
+xl=  0
+xw=  0
+dwg= -6.9800000E-09
+dwb= 0.00
+vth0= -0.5840000 wvth0= 2.9999999E-08
+k1= 0.6896000
+k2= -3.2100000E-02
+k3= 37.3474000
+dvt0= 2.8656001
+dvt1= 0.7912000
+dvt2= -0.4012000
+dvt0w= 0.00
+dvt1w= 5.3000000E+06
+dvt2w= -3.2000000E-02
+nlx= 2.0000000E-08
+w0= 4.4000000E-06
+k3b= 0.3196000 pk3b= 2.9999999E-13
+ngate= 1E30
+vsat= 6.0000000E+04 lvsat= 3.0000000E-03
+ua= 6.6400000E-10
+ub= 7.9800000E-19
+uc= -6.0000000E-12
+rdsw= 1.0300000E+03 lrdsw= 5.0000000E-05 prdsw= -1.5000000E-11
+prwb= -0.1500000 lprwb= 2.0000000E-08
+prwg= 1.3500000E-03
+wr= 1.0000000
+u0= 9.8500000E-03
+a0= 1.4005001
+keta= -5.0000000E-03 lketa= -8.0000000E-09
+a1= 0.00
+a2= 1.0000000
+ags= 0.2700000 lags= 2.0000000E-07
+b0= 0.00
+b1= 0.00
+voff= -0.1265000
+nfactor= 0.5829000
+cit= 0.00
+cdsc= 2.3999999E-04
+cdscb= 0.00
+cdscd= 0
+eta0= 0.5677900
+etab= -0.2000000
+dsub= 1.0000000
+pclm= 2.2564640
+pdiblc1= 4.9547720E-03
+pdiblc2= 8.2522830E-04
+pdiblcb= 0.00
+drout= 4.8592700E-02
+pscbe1= 8.0000000E+08
+pscbe2= 5.0000000E-05
+pvag= 0.9856056
+delta= 1.0000000E-02
+alpha0= 0.00
+beta0= 30.0000000
+kt1= -0.2087135
+kt2= -2.9999999E-02
+at= 1.0000000E+03
+ute= -0.9000000
+ua1= 7.0132940E-10
+ub1= -9.0000000E-19 wub1= 5.0000000E-26
+uc1= -1.0000000E-13
+kt1l= -4.4062380E-10
+prt= -2.0000000E+02
+cj= 1.325606E-03
+mj= 0.5133044
+pb= 0.8900552
+cjsw= 4.367354E-11
+mjsw= 0.0109312
+pbsw= 1.925715E-02
+cjswg= 4.53E-10
+mjswg= 0.244
+pbswg= 0.826
+cta= 1.026209E-03
+ctp= 5.611074E-04
+pta= 1.496444E-03
+ptp= 1.546467E-03
+js=1e-14
+jsw=0
+n=1
+xti=3.00
+cgdo=2.7E-10
+cgso=2.7E-10
+cgbo=1.0E-13
+capmod= 2
+nqsmod= 0
+elm= 5
+xpart= 0
+cgsl= 1.73E-10
+cgdl= 1.73E-10
+ckappa= 0.1
+cf= 0
+clc= 1E-08
+cle= 2.5
+dlc= 3.8E-08
+dwc= 2.75E-08
+vfbcv= -1
